// top
simulator lang=spectre
include "lib.scs"
subckt top (a b)
x1 (a b) leaf w=1u
x2 a b leaf w=2u
m1 (a b 0 0) nch_mod w=1u
f1 (a b) cccs probe=v1 gain=2
ends top
