// A made-up Spectre statistics table (Spectre Reference 19.1 p.179: "Correlation
// coefficients can be constants or expressions"): a 2x2 correlate whose cc
// is an expression, which SPICE writes in the 2x2 Cholesky closed form
// (b's draw is cc*z1 + sqrt(1-cc*cc)*z2), inside a library section.
simulator lang=spectre
library mc
section tt
parameters k=0.5 a=1 b=2
statistics {
  process {
    vary a dist=gauss std=0.1
    vary b dist=gauss std=0.2
  }
  correlate param=[a b] cc=k
}
endsection tt
endlibrary mc
