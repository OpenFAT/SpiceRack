* Shared by every corner of models.lib.
.param toxe_shared=4e-9
