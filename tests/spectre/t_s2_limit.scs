// t_s2_limit.scs

simulator lang=spectre

real rack_limit(real nom, real avar, real u) {
    return (u > 0) ? nom + avar : ((u < 0) ? nom - avar : nom);
}
parameters rack_r1_r_1=0
statistics {
    process {
        vary rack_r1_r_1 dist=unif N=1
    }
}

v1 (in 0) vsource dc=1
r1 (in out) resistor r=rack_limit(1k,50, rack_r1_r_1)
r2 (out 0) resistor r=1k

op1 dc
mc1 montecarlo numruns=2000 seed=1 variations=all {
  dcmc dc
}
