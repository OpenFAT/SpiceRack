// t_s1_nominal.scs

simulator lang=spectre

real rack_agauss(real nom, real avar, real sigma, real z) {
    return nom + ((avar > 0 && sigma > 0) ? avar : 0) / ((sigma > 0) ? sigma : 1) * z;
}
real rack_aunif(real nom, real avar, real u) {
    return nom + avar * u;
}
real rack_limit(real nom, real avar, real u) {
    return (u > 0) ? nom + avar : ((u < 0) ? nom - avar : nom);
}
parameters rack_r1_r_1=0 rack_r1_r_2=0 rack_r1_r_3=0
statistics {
    process {
        vary rack_r1_r_1 dist=gauss std=1
        vary rack_r1_r_2 dist=unif N=1
        vary rack_r1_r_3 dist=unif N=1
    }
}

v1 (in 0) vsource dc=1
r1 (in out) resistor r=rack_agauss(1k,100,3, rack_r1_r_1)+rack_aunif(0,100, rack_r1_r_2)+rack_limit(0,50, rack_r1_r_3)
r2 (out 0) resistor r=1k

op1 dc
